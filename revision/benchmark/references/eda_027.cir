* Inverting active first-order low-pass, cutoff approximately 1 kHz.
VIN IN 0 DC 0 AC 1
VCC VCC 0 12
VEE VEE 0 -12
RIN IN NM 15.915k
RF OUT NM 15.915k
CF OUT NM 10n
XU1 0 NM VCC VEE OUT LM2904
CBP VCC 0 100n
CBN VEE 0 100n
RLOAD OUT 0 100k
.end
