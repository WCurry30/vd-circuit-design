* Two capacitively coupled CE stages, gain approximately +25.
VIN IN 0 DC 0 AC 1
VDD VCC 0 12
CIN IN B1 10u
RB11 VCC B1 47k
RB12 B1 0 6.8k
RC1 VCC C1 2.2k
RE1 E1 0 330
Q1 C1 B1 E1 2N2222
CC C1 B2 10u
RB21 VCC B2 47k
RB22 B2 0 6.8k
RC2 VCC C2 2.2k
RE2 E2 0 330
Q2 C2 B2 E2 2N2222
COUT C2 OUT 10u
RLOAD OUT 0 10k
.end
