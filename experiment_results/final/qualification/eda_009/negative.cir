* Passive RC low-pass, cutoff approximately 1 kHz, unloaded output.
VIN IN 0 DC 0 AC 1
R1 IN OUT 159.15k
C1 OUT 0 10n
.end
