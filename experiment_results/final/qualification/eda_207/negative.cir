* Loaded Zener reference at 9 V and 12 V input.
VDD VCC 0 9
RS VCC OUT 220
DZ 0 OUT 1N4733A
* missing load
CB OUT 0 100n
.end
