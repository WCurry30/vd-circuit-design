* Microphone preamplifier interface, gain approximately 100.
VIN IN 0 DC 0 AC 1
VCC VCC 0 12
VEE VEE 0 -12
* missing microphone bias
CIN IN NP 10u
RBIAS NP 0 100k
RG NM 0 1k
RF OUT NM 99k
XU1 NP NM VCC VEE OUT LM2904
RLOAD OUT 0 100k
.end
