* Low-voltage op-amp/NMOS LED current loop, 10 mA at 5 V.
VDD VCC 0 5
RREF1 VCC REF 49k
RREF2 REF 0 1k
XU1 REF SENSE VCC 0 GATE LM2904
Q1 OUT GATE SENSE 2N2222
RSENSE SENSE 0 10
DLED VCC LED_C LED
VLOAD LED_C OUT 0
CB VCC 0 100n
.end
