* shared evaluator deck
* unified fixed-model evaluation
* Op-amp/NMOS LED current loop, 20 mA at 5 V.
VDD VCC 0 5
RREF1 VCC REF 24k
RREF2 REF 0 1k
XU1 REF SENSE VCC 0 GATE LM2904
Q1 OUT GATE SENSE 2N2222
RSENSE SENSE 0 10
DLED VCC LED_C LED
VLOAD LED_C OUT 0
CB VCC 0 100n
*//////////////////////////////////////////////////////////
*LM2904 DUAL OPERATIONAL AMPLIFIER MACRO-MODEL
*//////////////////////////////////////////////////////////
*
* connections:      non-inverting input
*                   |   inverting input
*                   |   |   positive power supply
*                   |   |   |   negative power supply
*                   |   |   |   |   output
*                   |   |   |   |   |
*                   |   |   |   |   |
*$
.SUBCKT LM2904   1   2  99  50  28
*
*Features:
*Eliminates need for dual supplies
*Large DC voltage gain =              100dB
*High bandwidth =                      1MHz
*Low input offset voltage =             2mV
*Wide supply range =        +-1.5V to +-16V
*
*NOTE: Model is for single device only and simulated
*      supply current is 1/2 of total device current.
*      Output crossover distortion with dual supplies
*      is not modeled.
*
****************INPUT STAGE**************
*
IOS 2 1 5N
*^Input offset current
R1 1 3 500K
R2 3 2 500K
I1 99 4 100U
R3 5 50 517
R4 6 50 517
Q1 5 2 4 QX
Q2 6 7 4 QX
*Fp2=1.2 MHz
C4 5 6 128.27P
*
***********COMMON MODE EFFECT***********
*
I2 99 50 75U
*^Quiescent supply current
EOS 7 1 POLY(1) 16 49 2E-3 1
*Input offset voltage.^
R8 99 49 60K
R9 49 50 60K
*
*********OUTPUT VOLTAGE LIMITING********
V2 99 8 1.63
D1 9 8 DX
D2 10 9 DX
V3 10 50 .635
*
**************SECOND STAGE**************
*
EH 99 98 99 49 1
G1 98 9 POLY(1) 5 6 0 9.8772E-4 0 .3459
*Fp1=7.86 Hz
R5 98 9 101.2433MEG
C3 98 9 200P
*
***************POLE STAGE***************
*
*Fp=2 MHz
G3 98 15 9 49 1E-6
R12 98 15 1MEG
C5 98 15 7.9577E-14
*
*********COMMON-MODE ZERO STAGE*********
*
*Fpcm=10 KHz
G4 98 16 3 49 5.6234E-8
L2 98 17 15.9M
R13 17 16 1K
*
**************OUTPUT STAGE**************
*
F6 50 99 POLY(1) V6 300U 1
E1 99 23 99 15 1
R16 24 23 17.5
D5 26 24 DX
V6 26 22 .63V
R17 23 25 17.5
D6 25 27 DX
V7 22 27 .63V
V5 22 21 0.27V
D4 21 15 DX
V4 20 22 0.27V
D3 15 20 DX
L3 22 28 500P
RL3 22 28 100K
*
***************MODELS USED**************
*
.MODEL DX D(IS=1E-15)
.MODEL QX PNP(BF=1.111E3)
*
.ENDS
*$

* Fixed compact models for reference qualification, version 1.
* 2N2222, LED, and 1N4733A copied from the project's existing SpiceEngine.
* EDA_NMOS is an explicitly generic Level-1 device, not a manufacturer model.
.model 2N2222 NPN(Is=14.34f Xti=3 Eg=1.11 Vaf=128.2 Bf=255.9 Ne=1.307 Ise=14.34f Ikf=.2847 Xtb=1.5 Br=6.092 Nc=2 Isc=0 Ikr=0 Rc=1 Cjc=7.306p Mjc=.3416 Vjc=.75 Fc=.5 Cje=22.01p Mje=.377 Vje=.75 Tr=46.91n Tf=411.1p Itf=.6 Vtf=1.7 Xtf=3 Rb=10)
.model LED D(Is=1e-20 N=2 Eg=2.2 Cjo=50p M=.5)
.model 1N4733A D(Is=1n N=1 BV=5.1 IBV=49m Cjo=550p)
.model EDA_NMOS NMOS(LEVEL=1 VTO=1 KP=0.1 LAMBDA=0.01)

.control
set filetype=ascii
op
wrdata /Users/zoe/Desktop/CodeX/EDA_Document/EDA_Last/experiment_results/final/qualification/eda_037/negative/conditions/condition_01/numeric_trace.txt i(VLOAD)
quit
.endc
.end
