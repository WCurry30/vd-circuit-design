* Single-supply AC-coupled audio preamplifier, gain 11.
VIN IN 0 DC 0 AC 1
VCC VCC 0 12
RVM1 VCC VBIAS 47k
RVM2 VBIAS 0 47k
CVM VBIAS 0 100u
CIN IN NP 10u
RBIAS NP VBIAS 100k
RG NM VBIAS 10k
RF AOUT NM 100k
XU1 NP NM VCC 0 AOUT LM2904
RBYPASS AOUT OUT 1m
RLOAD OUT 0 100k
.end
