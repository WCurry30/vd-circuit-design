VCC VCC 0 DC 12
VEE VEE 0 DC -12
V1 IN 0 DC 0 AC 1

* First RC stage
R_PART1 IN N1 318.3
C_PART2 N1 0 1u
X_PART3 N1 N2 VCC VEE N2 LM2904

* Second RC stage
R_PART1_2 N2 N3 318.3
C_PART2_2 N3 0 1u
X_PART3_2 N3 OUT VCC VEE OUT LM2904

* Decoupling capacitor
CDEC VCC 0 100n
